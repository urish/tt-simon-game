* ring_osc.spice - transient SPICE check of the 13-stage GF180 ring oscillator.
*
* Mirrors src/ring_osc.v: 13 inverters in a loop, closed through an AND2 enable.
* Each ring node carries a realistic 14 fF load (routing + fanout); see README.md
* for why a 2 fF schematic estimate was too optimistic and how 14 fF was calibrated.
*
* gf180mcu_fd_sc_mcu7t5v0 cell pin order: I ZN VDD VNW VPW VSS (VNW=VDD, VPW=VSS).

V1 VSS 0 0
V2 VDD VSS 3.3

* 13-inverter ring. nfb (AND2 output) -> inv chain -> clk_out -> AND2.A2.
x1  nfb  n1      VDD VDD VSS VSS gf180mcu_fd_sc_mcu7t5v0__clkinv_1
x2  n1   n2      VDD VDD VSS VSS gf180mcu_fd_sc_mcu7t5v0__clkinv_1
x3  n2   n3      VDD VDD VSS VSS gf180mcu_fd_sc_mcu7t5v0__clkinv_1
x4  n3   n4      VDD VDD VSS VSS gf180mcu_fd_sc_mcu7t5v0__clkinv_1
x5  n4   n5      VDD VDD VSS VSS gf180mcu_fd_sc_mcu7t5v0__clkinv_1
x6  n5   n6      VDD VDD VSS VSS gf180mcu_fd_sc_mcu7t5v0__clkinv_1
x7  n6   n7      VDD VDD VSS VSS gf180mcu_fd_sc_mcu7t5v0__clkinv_1
x8  n7   n8      VDD VDD VSS VSS gf180mcu_fd_sc_mcu7t5v0__clkinv_1
x9  n8   n9      VDD VDD VSS VSS gf180mcu_fd_sc_mcu7t5v0__clkinv_1
x10 n9   n10     VDD VDD VSS VSS gf180mcu_fd_sc_mcu7t5v0__clkinv_1
x11 n10  n11     VDD VDD VSS VSS gf180mcu_fd_sc_mcu7t5v0__clkinv_1
x12 n11  n12     VDD VDD VSS VSS gf180mcu_fd_sc_mcu7t5v0__clkinv_1
x13 n12  clk_out VDD VDD VSS VSS gf180mcu_fd_sc_mcu7t5v0__clkinv_1

* Enable: AND2(en, clk_out) -> nfb closes the loop; BUF holds en high.
x14 en   clk_out nfb VDD VDD VSS VSS gf180mcu_fd_sc_mcu7t5v0__and2_1
x15 VDD  en          VDD VDD VSS VSS gf180mcu_fd_sc_mcu7t5v0__buf_1

* Per-node load capacitors (see header).
C1  nfb     VSS 14f
C2  n1      VSS 14f
C3  n2      VSS 14f
C4  n3      VSS 14f
C5  n4      VSS 14f
C6  n5      VSS 14f
C7  n6      VSS 14f
C8  n7      VSS 14f
C9  n8      VSS 14f
C10 n9      VSS 14f
C11 n10     VSS 14f
C12 n11     VSS 14f
C13 n12     VSS 14f
C14 clk_out VSS 14f

.include design.ngspice
.lib sm141064.ngspice typical
.include gf180mcu_fd_sc_mcu7t5v0.spice

.ic v(nfb)=0

.control
save clk_out
tran 5p 200n uic
* skip startup; measure one period well past the transient
meas tran tp TRIG v(clk_out) VAL=1.65 RISE=8 TARG v(clk_out) VAL=1.65 RISE=9
let fmhz = 1 / tp / 1e6
print fmhz
.endc
.end
